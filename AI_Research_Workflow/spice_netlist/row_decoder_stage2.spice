** sch_path: /home/vijaykumar/internship/SRAM_SKY130/task2/schematics/row_decoder_stage2.sch
**.subckt row_decoder_stage2

************************************************
* 2-Input CMOS NAND Gate
************************************************

* PMOS Pull-up Network (Parallel)

XM1 Y A Vdd Vdd sky130_fd_pr__pfet_01v8 L=0.15 W=1
XM2 Y B Vdd Vdd sky130_fd_pr__pfet_01v8 L=0.15 W=1

************************************************
* NMOS Pull-down Network (Series)
************************************************

XM3 Y A N1 0 sky130_fd_pr__nfet_01v8 L=0.15 W=0.42
XM4 N1 B 0 0 sky130_fd_pr__nfet_01v8 L=0.15 W=0.42

************************************************
* Power Supply
************************************************

VVDD Vdd 0 1.8

************************************************
* Input A
************************************************

VA A 0 PULSE(
+0
+1.8
+2n
+100p
+100p
+10n
+20n)

************************************************
* Input B
************************************************

VB B 0 PULSE(
+0
+1.8
+4n
+100p
+100p
+20n
+40n)

************************************************
* Output Load
************************************************

CY Y 0 20f

************************************************
* SKY130 Library
************************************************

.lib /home/vijaykumar/pdk/open_pdks/sky130/sky130A/libs.tech/ngspice/sky130.lib.spice tt

************************************************
* User Architecture
************************************************

.control

tran 0.02n 40n

plot v(A)+6 v(B)+4 v(Y)

.endc

************************************************

.end
