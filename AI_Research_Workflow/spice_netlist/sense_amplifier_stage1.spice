** sch_path: /home/vijaykumar/internship/SRAM_SKY130/task2/schematics/sense_amplifier_stage1.sch
**.subckt sense_amplifier_stage1

************************************************
* Cross-Coupled PMOS Latch
************************************************

XM1 OUT  OUTB Vdd Vdd sky130_fd_pr__pfet_01v8 L=0.15 W=1
XM2 OUTB OUT  Vdd Vdd sky130_fd_pr__pfet_01v8 L=0.15 W=1

************************************************
* Cross-Coupled NMOS Latch
************************************************

XM3 OUT  OUTB 0 0 sky130_fd_pr__nfet_01v8 L=0.15 W=0.42
XM4 OUTB OUT  0 0 sky130_fd_pr__nfet_01v8 L=0.15 W=0.42

************************************************
* Differential Inputs
************************************************

VBL BL 0 PULSE(
+1.80
+1.70
+5n
+100p
+100p
+10n
+20n)

VBLB BLB 0 PULSE(
+1.70
+1.80
+5n
+100p
+100p
+10n
+20n)

************************************************
* Weak Coupling to Inputs
************************************************

RBL  BL  OUT  10k
RBLB BLB OUTB 10k

************************************************
* Power Supply
************************************************

VVDD Vdd 0 1.8

************************************************
* Output Loads
************************************************

COUT  OUT  0 20f
COUTB OUTB 0 20f

************************************************
* User Architecture
************************************************

.lib /home/vijaykumar/pdk/open_pdks/sky130/sky130A/libs.tech/ngspice/sky130.lib.spice tt

.control

tran 0.02n 30n

plot v(BL)+6 v(BLB)+4 v(OUT)+2 v(OUTB)

.endc

.end
