** sch_path: /home/vijaykumar/internship/SRAM_SKY130/task2/schematics/row_decoder_stage1.sch
**.subckt row_decoder_stage1

************************************************
* CMOS Inverter for A0
************************************************

XM1 A0B A0 0   0   sky130_fd_pr__nfet_01v8 L=0.15 W=0.42
XM2 A0B A0 Vdd Vdd sky130_fd_pr__pfet_01v8 L=0.15 W=1

************************************************
* CMOS Inverter for A1
************************************************

XM3 A1B A1 0   0   sky130_fd_pr__nfet_01v8 L=0.15 W=0.42
XM4 A1B A1 Vdd Vdd sky130_fd_pr__pfet_01v8 L=0.15 W=1

************************************************
* Power Supply
************************************************

VVDD Vdd 0 1.8

************************************************
* Address Inputs
************************************************

VA0 A0 0 PULSE(
+0
+1.8
+2n
+100p
+100p
+10n
+20n)

VA1 A1 0 PULSE(
+0
+1.8
+4n
+100p
+100p
+20n
+40n)

************************************************
* Output Loads
************************************************

CA0B A0B 0 20f
CA1B A1B 0 20f

************************************************
* User Architecture
************************************************

.lib /home/vijaykumar/pdk/open_pdks/sky130/sky130A/libs.tech/ngspice/sky130.lib.spice tt

.control

tran 0.02n 40n

plot v(A0)+6 v(A1)+4 v(A0B)+2 v(A1B)

.endc

************************************************

.end
