** sch_path: /home/vijaykumar/internship/SRAM_SKY130/task2/schematics/row_decoder_stage3.sch
**.subckt row_decoder_stage3

************************************************
* Stage 1 : 2-Input CMOS NAND
************************************************

* PMOS Pull-up Network
XM1 NOUT A Vdd Vdd sky130_fd_pr__pfet_01v8 L=0.15 W=1
XM2 NOUT B Vdd Vdd sky130_fd_pr__pfet_01v8 L=0.15 W=1

* NMOS Pull-down Network
XM3 NOUT A N1 0 sky130_fd_pr__nfet_01v8 L=0.15 W=0.42
XM4 N1   B 0  0 sky130_fd_pr__nfet_01v8 L=0.15 W=0.42

************************************************
* Stage 2 : CMOS Inverter
************************************************

XM5 Y NOUT 0   0   sky130_fd_pr__nfet_01v8 L=0.15 W=0.42
XM6 Y NOUT Vdd Vdd sky130_fd_pr__pfet_01v8 L=0.15 W=1

************************************************
* Supply
************************************************

VVDD Vdd 0 1.8

************************************************
* Input A
************************************************

VA A 0 PULSE(
+0
+1.8
+2n
+100p
+100p
+10n
+20n)

************************************************
* Input B
************************************************

VB B 0 PULSE(
+0
+1.8
+4n
+100p
+100p
+20n
+40n)

************************************************
* Output Loads
************************************************

CNAND NOUT 0 20f
COUT  Y    0 20f

************************************************
* SKY130 Library
************************************************

.lib /home/vijaykumar/pdk/open_pdks/sky130/sky130A/libs.tech/ngspice/sky130.lib.spice tt

************************************************
* User Architecture
************************************************

.control

tran 0.02n 40n

plot v(A)+8 v(B)+6 v(NOUT)+4 v(Y)

.endc

************************************************

.end
