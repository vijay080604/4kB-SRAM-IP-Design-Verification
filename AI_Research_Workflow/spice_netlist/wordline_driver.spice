** sch_path: /home/vijaykumar/internship/SRAM_SKY130/task2/schematics/wordline_driver.sch
**.subckt wordline_driver

************************************************
* First Stage CMOS Inverter
************************************************

XM1 N1 DIN 0 0 sky130_fd_pr__nfet_01v8 L=0.15 W=0.42
XM2 N1 DIN Vdd Vdd sky130_fd_pr__pfet_01v8 L=0.15 W=1

************************************************
* Second Stage CMOS Inverter
************************************************

XM3 WL N1 0 0 sky130_fd_pr__nfet_01v8 L=0.15 W=0.84
XM4 WL N1 Vdd Vdd sky130_fd_pr__pfet_01v8 L=0.15 W=2

************************************************
* Supply
************************************************

V1 DIN 0 PULSE(0 1.8 2n 100p 100p 5n 10n)

V2 Vdd 0 1.8

************************************************
* Wordline Load
************************************************

C1 WL 0 20f

**** begin user architecture code

.lib /home/vijaykumar/pdk/open_pdks/sky130/sky130A/libs.tech/ngspice/sky130.lib.spice tt

.control

tran 0.05n 20n

plot v(DIN) v(N1) v(WL)

.endc

**** end user architecture code

.end
