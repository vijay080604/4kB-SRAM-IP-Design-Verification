** sch_path: /home/vijaykumar/internship/sram_sky130/task2/schematics/snm_hold.sch
**.subckt snm_hold

************************************************
* 6T SRAM CELL
************************************************

* Cross-coupled inverter 1
XM1 Q     QB    0   0   sky130_fd_pr__nfet_01v8 L=0.15 W=0.42
XM2 Q     QB    VDD VDD sky130_fd_pr__pfet_01v8 L=0.15 W=1

* Cross-coupled inverter 2
XM3 QB    Q     0   0   sky130_fd_pr__nfet_01v8 L=0.15 W=0.42
XM4 QB    Q     VDD VDD sky130_fd_pr__pfet_01v8 L=0.15 W=1

* Access Transistors (WL LOW)
XM5 BL    WL    Q    0  sky130_fd_pr__nfet_01v8 L=0.15 W=1
XM6 BLB   WL    QB   0  sky130_fd_pr__nfet_01v8 L=0.15 W=1

************************************************
* Supply
************************************************

VVDD VDD 0 1.8

************************************************
* Hold Condition
************************************************

VWL WL 0 0

************************************************
* Floating Bitlines
************************************************

CBL  BL  0 100f
CBLB BLB 0 100f

************************************************
* Noise Injection
************************************************

VNOISE QN 0 0

R1 Q  QN 1m

************************************************
* Initial Conditions
************************************************

.ic V(Q)=1.8
.ic V(QB)=0

************************************************
* Verified SKY130 Library
************************************************

.lib /home/vijaykumar/pdk/open_pdks/sky130/sky130A/libs.tech/ngspice/sky130.lib.spice tt

.control

set wr_vecnames
set wr_singlescale

dc VNOISE 0 1.8 0.002

wrdata snm_hold_dc.csv v(Q) v(QB)

plot v(Q) v(QB)

.endc
