** sch_path: /home/vijaykumar/internship/SRAM_SKY130/task2/schematics/timing_stage1.sch
**.subckt timing_stage1

************************************************
* Supply
************************************************

VVDD VDD 0 1.8

************************************************
* Clock
************************************************

VCLK CLK 0 PULSE(
+0
+1.8
+0n
+100p
+100p
+5n
+10n)

************************************************
* Precharge Enable
* LOW = Precharge ON
************************************************

VPRE PRE 0 PULSE(
+0
+1.8
+4n
+100p
+100p
+12n
+24n)

************************************************
* Wordline
************************************************

VWL WL 0 PULSE(
+0
+1.8
+8n
+100p
+100p
+6n
+24n)

************************************************
* Sense Amplifier Enable
************************************************

VSA SA_EN 0 PULSE(
+0
+1.8
+12n
+100p
+100p
+4n
+24n)

************************************************
* Write Enable
************************************************

VWE WE 0 PULSE(
+0
+1.8
+18n
+100p
+100p
+4n
+48n)

************************************************
* User Architecture
************************************************

.control

tran 0.05n 50n

plot v(CLK)+8 v(PRE)+6 v(WL)+4 v(SA_EN)+2 v(WE)+0

.endc

.end
