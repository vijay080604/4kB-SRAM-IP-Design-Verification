** sch_path: /home/vijaykumar/internship/SRAM_SKY130/task2/schematics/precharge_ckt.sch
**.subckt precharge_ckt
XM1 bl pre_charge net1 net1 sky130_fd_pr__pfet_01v8 L=0.15 W=1 nf=1 ad=0.29 as=0.29 pd=2.58 ps=2.58 nrd=0.29 nrs=0.29 sa=0 sb=0
+ sd=0 mult=1
XM2 blbar pre_charge net1 net1 sky130_fd_pr__pfet_01v8 L=0.15 W=1 nf=1 ad=0.29 as=0.29 pd=2.58 ps=2.58 nrd=0.29 nrs=0.29 sa=0 sb=0
+ sd=0 mult=1
Vdd net1 0 1.8
C1 bl 0 10
C2 blbar 0 10
V1 pre_charge 0 pulse(1.8 0 1n 100p 100p 5n 10n)
**** begin user architecture code

.lib /home/vijaykumar/pdk/open_pdks/sky130/sky130A/libs.tech/ngspice/sky130.lib.spice tt

.control
tran 0.01n 20n
run
plot v(pre_charge) v(bl) v(blbar)
.endc

**** end user architecture code
**.ends
.end
